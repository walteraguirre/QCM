.SUBCKT HCU04pck 2 3 1 0
*IN=2, OUT=3, VCC=1, GND=0
XHCU04    20  30  10  90          INV0
XPK14  2  3 90 90 90 90  0 90 90 90 90 90 90  1
+     20 30 90 90 90 90 90 90 90 90 90 90 90 10 pk14
.ENDS
